* CDL Netlist generated by OpenROAD

*.BUSDELIMITER [

.SUBCKT UART_8N1_RX RX clk data[0] data[1] data[2] data[3]
+ data[4] data[5] data[6] data[7] rst VSS VDD
X_165_ rff2 VSS VSS VDD VDD _078_ sky130_fd_sc_hd__clkinv_1
X_166_ STATE[1] VSS VSS VDD VDD _079_ sky130_fd_sc_hd__clkinv_1
X_167_ STATE[3] VSS VSS VDD VDD _080_ sky130_fd_sc_hd__clkinv_1
X_168_ STATE[2] VSS VSS VDD VDD _081_ sky130_fd_sc_hd__clkinv_1
X_169_ rst VSS VSS VDD VDD _004_ sky130_fd_sc_hd__clkinv_1
X_170_ STATE[0] rff2 VSS VSS VDD VDD _082_ sky130_fd_sc_hd__lpflow_isobufsrc_1
X_171_ STATE[1] STATE[3] STATE[2] STATE[0] VSS VSS VDD VDD
+ _083_ sky130_fd_sc_hd__or4_1
X_172_ STATE[1] STATE[3] STATE[2] _082_ VSS VSS VDD VDD _084_
+ sky130_fd_sc_hd__nor4_2
X_173_ baud_counter[2] baud_counter[1] baud_counter[0] VSS
+ VSS VDD VDD _085_ sky130_fd_sc_hd__and3_1
X_174_ baud_counter[3] baud_counter[2] baud_counter[1] baud_counter[0]
+ VSS VSS VDD VDD _086_ sky130_fd_sc_hd__and4_1
X_175_ baud_counter[4] _086_ VSS VSS VDD VDD _087_ sky130_fd_sc_hd__and2_0
X_176_ baud_counter[5] baud_counter[4] _086_ VSS VSS VDD VDD
+ _088_ sky130_fd_sc_hd__and3_1
X_177_ baud_counter[7] baud_counter[6] _088_ VSS VSS VDD VDD
+ _089_ sky130_fd_sc_hd__and3_1
X_178_ baud_counter[8] baud_counter[7] baud_counter[6] _088_
+ VSS VSS VDD VDD _090_ sky130_fd_sc_hd__and4_1
X_179_ baud_counter[10] baud_counter[9] _090_ VSS VSS VDD
+ VDD _091_ sky130_fd_sc_hd__and3_1
X_180_ baud_counter[11] baud_counter[10] baud_counter[9] _090_
+ VSS VSS VDD VDD _092_ sky130_fd_sc_hd__nand4_1
X_181_ baud_counter[13] baud_counter[12] baud_counter[11]
+ _091_ VSS VSS VDD VDD _093_ sky130_fd_sc_hd__nand4_1
X_182_ bit_counter[2] bit_counter[1] bit_counter[0] bit_counter[3]
+ VSS VSS VDD VDD _094_ sky130_fd_sc_hd__or4b_1
X_183_ STATE[1] _094_ VSS VSS VDD VDD _095_ sky130_fd_sc_hd__nand2_1
X_184_ STATE[1] _094_ STATE[3] VSS VSS VDD VDD _096_ sky130_fd_sc_hd__a21oi_1
X_185_ _081_ _096_ VSS VSS VDD VDD _097_ sky130_fd_sc_hd__nand2_1
X_186_ baud_counter[12] baud_counter[11] _091_ baud_counter[13]
+ VSS VSS VDD VDD _098_ sky130_fd_sc_hd__a31o_1
X_187_ _093_ _097_ _098_ net1 baud_counter[13] VSS VSS VDD
+ VDD _077_ sky130_fd_sc_hd__a32o_1
X_188_ baud_counter[12] net1 VSS VSS VDD VDD _099_ sky130_fd_sc_hd__nand2_1
X_189_ baud_counter[8] baud_counter[7] VSS VSS VDD VDD _100_
+ sky130_fd_sc_hd__nor2_1
X_190_ baud_counter[13] baud_counter[8] baud_counter[7] VSS
+ VSS VDD VDD _101_ sky130_fd_sc_hd__nor3_1
X_191_ baud_counter[9] baud_counter[5] baud_counter[3] baud_counter[6]
+ VSS VSS VDD VDD _102_ sky130_fd_sc_hd__or4b_1
X_192_ baud_counter[12] baud_counter[10] VSS VSS VDD VDD _103_
+ sky130_fd_sc_hd__nand2_1
X_193_ baud_counter[13] baud_counter[11] _102_ _103_ VSS VSS
+ VDD VDD _104_ sky130_fd_sc_hd__nor4_1
X_194_ baud_counter[4] _085_ _100_ _104_ VSS VSS VDD VDD _105_
+ sky130_fd_sc_hd__nand4_1
X_195_ baud_counter[12] baud_counter[10] baud_counter[6] VSS
+ VSS VDD VDD _106_ sky130_fd_sc_hd__nand3_1
X_196_ baud_counter[13] baud_counter[11] baud_counter[9] _106_
+ VSS VSS VDD VDD _107_ sky130_fd_sc_hd__nor4_1
X_197_ baud_counter[8] baud_counter[7] baud_counter[5] baud_counter[3]
+ VSS VSS VDD VDD _108_ sky130_fd_sc_hd__nor4_1
X_198_ baud_counter[4] _085_ _107_ _108_ VSS VSS VDD VDD _109_
+ sky130_fd_sc_hd__and4_1
X_199_ _096_ _109_ VSS VSS VDD VDD _110_ sky130_fd_sc_hd__nor2_1
X_200_ STATE[2] _110_ VSS VSS VDD VDD _111_ sky130_fd_sc_hd__nor2_1
X_201_ baud_counter[12] _092_ VSS VSS VDD VDD _112_ sky130_fd_sc_hd__xor2_1
X_202_ _111_ _112_ _099_ VSS VSS VDD VDD _076_ sky130_fd_sc_hd__o21ai_0
X_203_ baud_counter[11] _083_ VSS VSS VDD VDD _113_ sky130_fd_sc_hd__nor2_1
X_204_ baud_counter[10] baud_counter[9] _090_ baud_counter[11]
+ VSS VSS VDD VDD _114_ sky130_fd_sc_hd__a31o_1
X_205_ baud_counter[11] rff2 VSS VSS VDD VDD _115_ sky130_fd_sc_hd__and2_0
X_206_ baud_counter[10] baud_counter[6] baud_counter[5] baud_counter[9]
+ VSS VSS VDD VDD _116_ sky130_fd_sc_hd__nor4bb_1
X_207_ baud_counter[12] baud_counter[11] baud_counter[1] baud_counter[0]
+ VSS VSS VDD VDD _117_ sky130_fd_sc_hd__and4b_1
X_208_ baud_counter[4] baud_counter[2] baud_counter[3] VSS
+ VSS VDD VDD _118_ sky130_fd_sc_hd__nor3b_1
X_209_ _101_ _116_ _117_ _118_ VSS VSS VDD VDD _119_ sky130_fd_sc_hd__nand4_1
X_210_ _115_ _119_ STATE[2] VSS VSS VDD VDD _120_ sky130_fd_sc_hd__o21ai_0
X_211_ _096_ _120_ VSS VSS VDD VDD _121_ sky130_fd_sc_hd__nand2_1
X_212_ _092_ _114_ _121_ VSS VSS VDD VDD _122_ sky130_fd_sc_hd__nand3_1
X_213_ _079_ _080_ _081_ _115_ VSS VSS VDD VDD _123_ sky130_fd_sc_hd__nand4_1
X_214_ _083_ _122_ _123_ _113_ VSS VSS VDD VDD _075_ sky130_fd_sc_hd__a31oi_1
X_215_ baud_counter[9] _090_ baud_counter[10] VSS VSS VDD
+ VDD _124_ sky130_fd_sc_hd__a21oi_1
X_216_ baud_counter[10] net1 VSS VSS VDD VDD _125_ sky130_fd_sc_hd__nand2_1
X_217_ _091_ _111_ _124_ _125_ VSS VSS VDD VDD _074_ sky130_fd_sc_hd__o31ai_1
X_218_ baud_counter[9] _090_ VSS VSS VDD VDD _126_ sky130_fd_sc_hd__xor2_1
X_219_ baud_counter[9] net1 _121_ _126_ VSS VSS VDD VDD _073_
+ sky130_fd_sc_hd__a22o_1
X_220_ baud_counter[8] _089_ VSS VSS VDD VDD _127_ sky130_fd_sc_hd__nor2_1
X_221_ _090_ _127_ VSS VSS VDD VDD _128_ sky130_fd_sc_hd__nor2_1
X_222_ baud_counter[8] _084_ _097_ _128_ VSS VSS VDD VDD _072_
+ sky130_fd_sc_hd__a22o_1
X_223_ baud_counter[6] _088_ baud_counter[7] VSS VSS VDD VDD
+ _129_ sky130_fd_sc_hd__a21oi_1
X_224_ _089_ _129_ VSS VSS VDD VDD _130_ sky130_fd_sc_hd__nor2_1
X_225_ baud_counter[7] _084_ _097_ _130_ VSS VSS VDD VDD _071_
+ sky130_fd_sc_hd__a22o_1
X_226_ baud_counter[6] net1 VSS VSS VDD VDD _131_ sky130_fd_sc_hd__nand2_1
X_227_ baud_counter[6] _088_ VSS VSS VDD VDD _132_ sky130_fd_sc_hd__xnor2_1
X_228_ _111_ _132_ _131_ VSS VSS VDD VDD _070_ sky130_fd_sc_hd__o21ai_0
X_229_ baud_counter[5] _084_ VSS VSS VDD VDD _133_ sky130_fd_sc_hd__nand2_1
X_230_ baud_counter[5] _087_ _121_ VSS VSS VDD VDD _134_ sky130_fd_sc_hd__o21ai_0
X_231_ _088_ _134_ _133_ VSS VSS VDD VDD _069_ sky130_fd_sc_hd__o21ai_0
X_232_ baud_counter[4] _084_ VSS VSS VDD VDD _135_ sky130_fd_sc_hd__nand2_1
X_233_ baud_counter[4] _086_ _110_ STATE[2] VSS VSS VDD VDD
+ _136_ sky130_fd_sc_hd__o22ai_1
X_234_ _087_ _136_ _135_ VSS VSS VDD VDD _068_ sky130_fd_sc_hd__o21ai_0
X_235_ baud_counter[3] _085_ VSS VSS VDD VDD _137_ sky130_fd_sc_hd__nor2_1
X_236_ baud_counter[3] _084_ VSS VSS VDD VDD _138_ sky130_fd_sc_hd__nand2_1
X_237_ _110_ _120_ VSS VSS VDD VDD _139_ sky130_fd_sc_hd__nor2b_1
X_238_ _086_ _137_ _139_ _138_ VSS VSS VDD VDD _067_ sky130_fd_sc_hd__o31ai_1
X_239_ baud_counter[1] baud_counter[0] _083_ baud_counter[2]
+ VSS VSS VDD VDD _140_ sky130_fd_sc_hd__a31oi_1
X_240_ STATE[2] _119_ VSS VSS VDD VDD _141_ sky130_fd_sc_hd__nand2_1
X_241_ _096_ _141_ _085_ VSS VSS VDD VDD _142_ sky130_fd_sc_hd__a21oi_1
X_242_ baud_counter[2] _084_ _142_ VSS VSS VDD VDD _143_ sky130_fd_sc_hd__a21oi_1
X_243_ _140_ _143_ VSS VSS VDD VDD _066_ sky130_fd_sc_hd__nor2_1
X_244_ baud_counter[1] baud_counter[0] VSS VSS VDD VDD _144_
+ sky130_fd_sc_hd__xnor2_1
X_245_ _081_ _119_ VSS VSS VDD VDD _145_ sky130_fd_sc_hd__nor2_1
X_246_ _115_ _145_ VSS VSS VDD VDD _146_ sky130_fd_sc_hd__nand2_1
X_247_ _144_ _146_ VSS VSS VDD VDD _147_ sky130_fd_sc_hd__nand2_1
X_248_ baud_counter[1] net1 _121_ _147_ VSS VSS VDD VDD _065_
+ sky130_fd_sc_hd__a22o_1
X_249_ baud_counter[0] _146_ VSS VSS VDD VDD _148_ sky130_fd_sc_hd__nand2_1
X_250_ baud_counter[0] net1 _121_ _148_ VSS VSS VDD VDD _064_
+ sky130_fd_sc_hd__a22o_1
X_251_ _095_ _105_ VSS VSS VDD VDD _149_ sky130_fd_sc_hd__nor2_1
X_252_ data_reg[7] rff2 _149_ VSS VSS VDD VDD _063_ sky130_fd_sc_hd__mux2_1
X_253_ data_reg[6] data_reg[7] _149_ VSS VSS VDD VDD _062_
+ sky130_fd_sc_hd__mux2_1
X_254_ data_reg[5] data_reg[6] _149_ VSS VSS VDD VDD _061_
+ sky130_fd_sc_hd__mux2_1
X_255_ data_reg[4] data_reg[5] _149_ VSS VSS VDD VDD _060_
+ sky130_fd_sc_hd__mux2_1
X_256_ data_reg[3] data_reg[4] _149_ VSS VSS VDD VDD _059_
+ sky130_fd_sc_hd__mux2_1
X_257_ data_reg[2] data_reg[3] _149_ VSS VSS VDD VDD _058_
+ sky130_fd_sc_hd__mux2_1
X_258_ data_reg[1] data_reg[2] _149_ VSS VSS VDD VDD _057_
+ sky130_fd_sc_hd__mux2_1
X_259_ data_reg[0] data_reg[1] _149_ VSS VSS VDD VDD _056_
+ sky130_fd_sc_hd__mux2_1
X_260_ _078_ _080_ _105_ VSS VSS VDD VDD _150_ sky130_fd_sc_hd__or3_1
X_261_ data_reg[7] data[7] _150_ VSS VSS VDD VDD _055_ sky130_fd_sc_hd__mux2_1
X_262_ data_reg[6] data[6] _150_ VSS VSS VDD VDD _054_ sky130_fd_sc_hd__mux2_1
X_263_ data_reg[5] data[5] _150_ VSS VSS VDD VDD _053_ sky130_fd_sc_hd__mux2_1
X_264_ data_reg[4] data[4] _150_ VSS VSS VDD VDD _052_ sky130_fd_sc_hd__mux2_1
X_265_ data_reg[3] data[3] _150_ VSS VSS VDD VDD _051_ sky130_fd_sc_hd__mux2_1
X_266_ data_reg[2] data[2] _150_ VSS VSS VDD VDD _050_ sky130_fd_sc_hd__mux2_1
X_267_ data_reg[1] data[1] _150_ VSS VSS VDD VDD _049_ sky130_fd_sc_hd__mux2_1
X_268_ data_reg[0] data[0] _150_ VSS VSS VDD VDD _048_ sky130_fd_sc_hd__mux2_1
X_269_ bit_counter[1] bit_counter[0] VSS VSS VDD VDD _151_
+ sky130_fd_sc_hd__and2_0
X_270_ STATE[2] STATE[0] _078_ VSS VSS VDD VDD _152_ sky130_fd_sc_hd__o21ai_0
X_271_ STATE[2] _119_ _152_ _079_ VSS VSS VDD VDD _153_ sky130_fd_sc_hd__a22oi_1
X_272_ _095_ _153_ VSS VSS VDD VDD _154_ sky130_fd_sc_hd__and2_0
X_273_ _109_ _153_ VSS VSS VDD VDD _155_ sky130_fd_sc_hd__nand2_1
X_274_ _095_ _109_ _153_ VSS VSS VDD VDD _156_ sky130_fd_sc_hd__o21ai_0
X_275_ _095_ _109_ _151_ _153_ VSS VSS VDD VDD _157_ sky130_fd_sc_hd__o211ai_1
X_276_ _095_ _109_ _151_ _153_ bit_counter[2] VSS VSS VDD
+ VDD _158_ sky130_fd_sc_hd__o2111ai_1
X_277_ bit_counter[3] _158_ VSS VSS VDD VDD _159_ sky130_fd_sc_hd__xor2_1
X_278_ _154_ _159_ VSS VSS VDD VDD _047_ sky130_fd_sc_hd__nor2_1
X_279_ bit_counter[2] _157_ VSS VSS VDD VDD _160_ sky130_fd_sc_hd__xor2_1
X_280_ _079_ _153_ _160_ VSS VSS VDD VDD _046_ sky130_fd_sc_hd__a21oi_1
X_281_ bit_counter[1] bit_counter[0] STATE[1] VSS VSS VDD
+ VDD _161_ sky130_fd_sc_hd__o21ai_0
X_282_ bit_counter[1] _156_ VSS VSS VDD VDD _162_ sky130_fd_sc_hd__nand2_1
X_283_ _151_ _156_ _161_ _162_ VSS VSS VDD VDD _045_ sky130_fd_sc_hd__o31ai_1
X_284_ bit_counter[0] _155_ VSS VSS VDD VDD _163_ sky130_fd_sc_hd__xor2_1
X_285_ _154_ _163_ VSS VSS VDD VDD _044_ sky130_fd_sc_hd__nor2_1
X_286_ _079_ _094_ _109_ _080_ VSS VSS VDD VDD _003_ sky130_fd_sc_hd__o22ai_1
X_287_ STATE[0] _145_ rff2 VSS VSS VDD VDD _164_ sky130_fd_sc_hd__o21ai_0
X_288_ _080_ _105_ _164_ VSS VSS VDD VDD _000_ sky130_fd_sc_hd__o21ai_0
X_289_ _081_ _115_ _119_ _095_ VSS VSS VDD VDD _001_ sky130_fd_sc_hd__o31ai_1
X_290_ _082_ _141_ VSS VSS VDD VDD _002_ sky130_fd_sc_hd__nand2b_1
X_291_ rst VSS VSS VDD VDD _005_ sky130_fd_sc_hd__clkinv_1
X_292_ rst VSS VSS VDD VDD _006_ sky130_fd_sc_hd__clkinv_1
X_293_ rst VSS VSS VDD VDD _007_ sky130_fd_sc_hd__clkinv_1
X_294_ rst VSS VSS VDD VDD _008_ sky130_fd_sc_hd__clkinv_1
X_295_ rst VSS VSS VDD VDD _009_ sky130_fd_sc_hd__clkinv_1
X_296_ rst VSS VSS VDD VDD _010_ sky130_fd_sc_hd__clkinv_1
X_297_ rst VSS VSS VDD VDD _011_ sky130_fd_sc_hd__clkinv_1
X_298_ rst VSS VSS VDD VDD _012_ sky130_fd_sc_hd__clkinv_1
X_299_ rst VSS VSS VDD VDD _013_ sky130_fd_sc_hd__clkinv_1
X_300_ rst VSS VSS VDD VDD _014_ sky130_fd_sc_hd__clkinv_1
X_301_ rst VSS VSS VDD VDD _015_ sky130_fd_sc_hd__clkinv_1
X_302_ rst VSS VSS VDD VDD _016_ sky130_fd_sc_hd__clkinv_1
X_303_ rst VSS VSS VDD VDD _017_ sky130_fd_sc_hd__clkinv_1
X_304_ rst VSS VSS VDD VDD _018_ sky130_fd_sc_hd__clkinv_1
X_305_ rst VSS VSS VDD VDD _019_ sky130_fd_sc_hd__clkinv_1
X_306_ rst VSS VSS VDD VDD _020_ sky130_fd_sc_hd__clkinv_1
X_307_ rst VSS VSS VDD VDD _021_ sky130_fd_sc_hd__clkinv_1
X_308_ rst VSS VSS VDD VDD _022_ sky130_fd_sc_hd__clkinv_1
X_309_ rst VSS VSS VDD VDD _023_ sky130_fd_sc_hd__clkinv_1
X_310_ rst VSS VSS VDD VDD _024_ sky130_fd_sc_hd__clkinv_1
X_311_ rst VSS VSS VDD VDD _025_ sky130_fd_sc_hd__clkinv_1
X_312_ rst VSS VSS VDD VDD _026_ sky130_fd_sc_hd__clkinv_1
X_313_ rst VSS VSS VDD VDD _027_ sky130_fd_sc_hd__clkinv_1
X_314_ rst VSS VSS VDD VDD _028_ sky130_fd_sc_hd__clkinv_1
X_315_ rst VSS VSS VDD VDD _029_ sky130_fd_sc_hd__clkinv_1
X_316_ rst VSS VSS VDD VDD _030_ sky130_fd_sc_hd__clkinv_1
X_317_ rst VSS VSS VDD VDD _031_ sky130_fd_sc_hd__clkinv_1
X_318_ rst VSS VSS VDD VDD _032_ sky130_fd_sc_hd__clkinv_1
X_319_ rst VSS VSS VDD VDD _033_ sky130_fd_sc_hd__clkinv_1
X_320_ rst VSS VSS VDD VDD _034_ sky130_fd_sc_hd__clkinv_1
X_321_ rst VSS VSS VDD VDD _035_ sky130_fd_sc_hd__clkinv_1
X_322_ rst VSS VSS VDD VDD _036_ sky130_fd_sc_hd__clkinv_1
X_323_ rst VSS VSS VDD VDD _037_ sky130_fd_sc_hd__clkinv_1
X_324_ rst VSS VSS VDD VDD _038_ sky130_fd_sc_hd__clkinv_1
X_325_ rst VSS VSS VDD VDD _039_ sky130_fd_sc_hd__clkinv_1
X_326_ rst VSS VSS VDD VDD _040_ sky130_fd_sc_hd__clkinv_1
X_327_ rst VSS VSS VDD VDD _041_ sky130_fd_sc_hd__clkinv_1
X_328_ rst VSS VSS VDD VDD _042_ sky130_fd_sc_hd__clkinv_1
X_329_ rst VSS VSS VDD VDD _043_ sky130_fd_sc_hd__clkinv_1
X_330_ clknet_2_1__leaf_clk _044_ _004_ VSS VSS VDD VDD bit_counter[0]
+ sky130_fd_sc_hd__dfrtp_1
X_331_ clknet_2_1__leaf_clk _045_ _005_ VSS VSS VDD VDD bit_counter[1]
+ sky130_fd_sc_hd__dfrtp_1
X_332_ clknet_2_1__leaf_clk _046_ _006_ VSS VSS VDD VDD bit_counter[2]
+ sky130_fd_sc_hd__dfrtp_1
X_333_ clknet_2_1__leaf_clk _047_ _007_ VSS VSS VDD VDD bit_counter[3]
+ sky130_fd_sc_hd__dfrtp_1
X_334_ clknet_2_0__leaf_clk _000_ _008_ VSS VSS VDD VDD STATE[0]
+ sky130_fd_sc_hd__dfstp_2
X_335_ clknet_2_1__leaf_clk _001_ _009_ VSS VSS VDD VDD STATE[1]
+ sky130_fd_sc_hd__dfrtp_1
X_336_ clknet_2_1__leaf_clk _002_ _010_ VSS VSS VDD VDD STATE[2]
+ sky130_fd_sc_hd__dfrtp_1
X_337_ clknet_2_1__leaf_clk _003_ _011_ VSS VSS VDD VDD STATE[3]
+ sky130_fd_sc_hd__dfrtp_1
X_338_ clknet_2_2__leaf_clk _048_ _012_ VSS VSS VDD VDD data[0]
+ sky130_fd_sc_hd__dfrtp_1
X_339_ clknet_2_2__leaf_clk _049_ _013_ VSS VSS VDD VDD data[1]
+ sky130_fd_sc_hd__dfrtp_1
X_340_ clknet_2_2__leaf_clk _050_ _014_ VSS VSS VDD VDD data[2]
+ sky130_fd_sc_hd__dfrtp_1
X_341_ clknet_2_2__leaf_clk _051_ _015_ VSS VSS VDD VDD data[3]
+ sky130_fd_sc_hd__dfrtp_1
X_342_ clknet_2_0__leaf_clk _052_ _016_ VSS VSS VDD VDD data[4]
+ sky130_fd_sc_hd__dfrtp_1
X_343_ clknet_2_0__leaf_clk _053_ _017_ VSS VSS VDD VDD data[5]
+ sky130_fd_sc_hd__dfrtp_1
X_344_ clknet_2_0__leaf_clk _054_ _018_ VSS VSS VDD VDD data[6]
+ sky130_fd_sc_hd__dfrtp_1
X_345_ clknet_2_0__leaf_clk _055_ _019_ VSS VSS VDD VDD data[7]
+ sky130_fd_sc_hd__dfrtp_1
X_346_ clknet_2_0__leaf_clk RX _020_ VSS VSS VDD VDD rff1
+ sky130_fd_sc_hd__dfstp_2
X_347_ clknet_2_0__leaf_clk rff1 _021_ VSS VSS VDD VDD rff2
+ sky130_fd_sc_hd__dfstp_2
X_348_ clknet_2_2__leaf_clk _056_ _022_ VSS VSS VDD VDD data_reg[0]
+ sky130_fd_sc_hd__dfrtp_1
X_349_ clknet_2_2__leaf_clk _057_ _023_ VSS VSS VDD VDD data_reg[1]
+ sky130_fd_sc_hd__dfrtp_1
X_350_ clknet_2_2__leaf_clk _058_ _024_ VSS VSS VDD VDD data_reg[2]
+ sky130_fd_sc_hd__dfrtp_1
X_351_ clknet_2_2__leaf_clk _059_ _025_ VSS VSS VDD VDD data_reg[3]
+ sky130_fd_sc_hd__dfrtp_1
X_352_ clknet_2_0__leaf_clk _060_ _026_ VSS VSS VDD VDD data_reg[4]
+ sky130_fd_sc_hd__dfrtp_1
X_353_ clknet_2_0__leaf_clk _061_ _027_ VSS VSS VDD VDD data_reg[5]
+ sky130_fd_sc_hd__dfrtp_1
X_354_ clknet_2_0__leaf_clk _062_ _028_ VSS VSS VDD VDD data_reg[6]
+ sky130_fd_sc_hd__dfrtp_1
X_355_ clknet_2_0__leaf_clk _063_ _029_ VSS VSS VDD VDD data_reg[7]
+ sky130_fd_sc_hd__dfrtp_1
X_356_ clknet_2_2__leaf_clk _064_ _030_ VSS VSS VDD VDD baud_counter[0]
+ sky130_fd_sc_hd__dfrtp_1
X_357_ clknet_2_2__leaf_clk _065_ _031_ VSS VSS VDD VDD baud_counter[1]
+ sky130_fd_sc_hd__dfrtp_1
X_358_ clknet_2_1__leaf_clk _066_ _032_ VSS VSS VDD VDD baud_counter[2]
+ sky130_fd_sc_hd__dfrtp_1
X_359_ clknet_2_3__leaf_clk _067_ _033_ VSS VSS VDD VDD baud_counter[3]
+ sky130_fd_sc_hd__dfrtp_1
X_360_ clknet_2_3__leaf_clk _068_ _034_ VSS VSS VDD VDD baud_counter[4]
+ sky130_fd_sc_hd__dfrtp_1
X_361_ clknet_2_3__leaf_clk _069_ _035_ VSS VSS VDD VDD baud_counter[5]
+ sky130_fd_sc_hd__dfrtp_1
X_362_ clknet_2_3__leaf_clk _070_ _036_ VSS VSS VDD VDD baud_counter[6]
+ sky130_fd_sc_hd__dfrtp_1
X_363_ clknet_2_3__leaf_clk _071_ _037_ VSS VSS VDD VDD baud_counter[7]
+ sky130_fd_sc_hd__dfrtp_1
X_364_ clknet_2_3__leaf_clk _072_ _038_ VSS VSS VDD VDD baud_counter[8]
+ sky130_fd_sc_hd__dfrtp_1
X_365_ clknet_2_2__leaf_clk _073_ _039_ VSS VSS VDD VDD baud_counter[9]
+ sky130_fd_sc_hd__dfrtp_1
X_366_ clknet_2_2__leaf_clk _074_ _040_ VSS VSS VDD VDD baud_counter[10]
+ sky130_fd_sc_hd__dfrtp_1
X_367_ clknet_2_3__leaf_clk _075_ _041_ VSS VSS VDD VDD baud_counter[11]
+ sky130_fd_sc_hd__dfrtp_1
X_368_ clknet_2_2__leaf_clk _076_ _042_ VSS VSS VDD VDD baud_counter[12]
+ sky130_fd_sc_hd__dfrtp_1
X_369_ clknet_2_3__leaf_clk _077_ _043_ VSS VSS VDD VDD baud_counter[13]
+ sky130_fd_sc_hd__dfrtp_1
XTAP_TAPCELL_ROW_0_0 VSS VDD sky130_fd_sc_hd__tapvpwrvgnd_1
XTAP_TAPCELL_ROW_0_1 VSS VDD sky130_fd_sc_hd__tapvpwrvgnd_1
XTAP_TAPCELL_ROW_0_2 VSS VDD sky130_fd_sc_hd__tapvpwrvgnd_1
XTAP_TAPCELL_ROW_0_3 VSS VDD sky130_fd_sc_hd__tapvpwrvgnd_1
XTAP_TAPCELL_ROW_0_4 VSS VDD sky130_fd_sc_hd__tapvpwrvgnd_1
XTAP_TAPCELL_ROW_1_5 VSS VDD sky130_fd_sc_hd__tapvpwrvgnd_1
XTAP_TAPCELL_ROW_1_6 VSS VDD sky130_fd_sc_hd__tapvpwrvgnd_1
XTAP_TAPCELL_ROW_2_7 VSS VDD sky130_fd_sc_hd__tapvpwrvgnd_1
XTAP_TAPCELL_ROW_2_8 VSS VDD sky130_fd_sc_hd__tapvpwrvgnd_1
XTAP_TAPCELL_ROW_2_9 VSS VDD sky130_fd_sc_hd__tapvpwrvgnd_1
XTAP_TAPCELL_ROW_3_10 VSS VDD sky130_fd_sc_hd__tapvpwrvgnd_1
XTAP_TAPCELL_ROW_3_11 VSS VDD sky130_fd_sc_hd__tapvpwrvgnd_1
XTAP_TAPCELL_ROW_4_12 VSS VDD sky130_fd_sc_hd__tapvpwrvgnd_1
XTAP_TAPCELL_ROW_4_13 VSS VDD sky130_fd_sc_hd__tapvpwrvgnd_1
XTAP_TAPCELL_ROW_4_14 VSS VDD sky130_fd_sc_hd__tapvpwrvgnd_1
XTAP_TAPCELL_ROW_5_15 VSS VDD sky130_fd_sc_hd__tapvpwrvgnd_1
XTAP_TAPCELL_ROW_5_16 VSS VDD sky130_fd_sc_hd__tapvpwrvgnd_1
XTAP_TAPCELL_ROW_6_17 VSS VDD sky130_fd_sc_hd__tapvpwrvgnd_1
XTAP_TAPCELL_ROW_6_18 VSS VDD sky130_fd_sc_hd__tapvpwrvgnd_1
XTAP_TAPCELL_ROW_6_19 VSS VDD sky130_fd_sc_hd__tapvpwrvgnd_1
XTAP_TAPCELL_ROW_7_20 VSS VDD sky130_fd_sc_hd__tapvpwrvgnd_1
XTAP_TAPCELL_ROW_7_21 VSS VDD sky130_fd_sc_hd__tapvpwrvgnd_1
XTAP_TAPCELL_ROW_8_22 VSS VDD sky130_fd_sc_hd__tapvpwrvgnd_1
XTAP_TAPCELL_ROW_8_23 VSS VDD sky130_fd_sc_hd__tapvpwrvgnd_1
XTAP_TAPCELL_ROW_8_24 VSS VDD sky130_fd_sc_hd__tapvpwrvgnd_1
XTAP_TAPCELL_ROW_9_25 VSS VDD sky130_fd_sc_hd__tapvpwrvgnd_1
XTAP_TAPCELL_ROW_9_26 VSS VDD sky130_fd_sc_hd__tapvpwrvgnd_1
XTAP_TAPCELL_ROW_10_27 VSS VDD sky130_fd_sc_hd__tapvpwrvgnd_1
XTAP_TAPCELL_ROW_10_28 VSS VDD sky130_fd_sc_hd__tapvpwrvgnd_1
XTAP_TAPCELL_ROW_10_29 VSS VDD sky130_fd_sc_hd__tapvpwrvgnd_1
XTAP_TAPCELL_ROW_11_30 VSS VDD sky130_fd_sc_hd__tapvpwrvgnd_1
XTAP_TAPCELL_ROW_11_31 VSS VDD sky130_fd_sc_hd__tapvpwrvgnd_1
XTAP_TAPCELL_ROW_12_32 VSS VDD sky130_fd_sc_hd__tapvpwrvgnd_1
XTAP_TAPCELL_ROW_12_33 VSS VDD sky130_fd_sc_hd__tapvpwrvgnd_1
XTAP_TAPCELL_ROW_12_34 VSS VDD sky130_fd_sc_hd__tapvpwrvgnd_1
XTAP_TAPCELL_ROW_13_35 VSS VDD sky130_fd_sc_hd__tapvpwrvgnd_1
XTAP_TAPCELL_ROW_13_36 VSS VDD sky130_fd_sc_hd__tapvpwrvgnd_1
XTAP_TAPCELL_ROW_14_37 VSS VDD sky130_fd_sc_hd__tapvpwrvgnd_1
XTAP_TAPCELL_ROW_14_38 VSS VDD sky130_fd_sc_hd__tapvpwrvgnd_1
XTAP_TAPCELL_ROW_14_39 VSS VDD sky130_fd_sc_hd__tapvpwrvgnd_1
XTAP_TAPCELL_ROW_15_40 VSS VDD sky130_fd_sc_hd__tapvpwrvgnd_1
XTAP_TAPCELL_ROW_15_41 VSS VDD sky130_fd_sc_hd__tapvpwrvgnd_1
XTAP_TAPCELL_ROW_16_42 VSS VDD sky130_fd_sc_hd__tapvpwrvgnd_1
XTAP_TAPCELL_ROW_16_43 VSS VDD sky130_fd_sc_hd__tapvpwrvgnd_1
XTAP_TAPCELL_ROW_16_44 VSS VDD sky130_fd_sc_hd__tapvpwrvgnd_1
XTAP_TAPCELL_ROW_17_45 VSS VDD sky130_fd_sc_hd__tapvpwrvgnd_1
XTAP_TAPCELL_ROW_17_46 VSS VDD sky130_fd_sc_hd__tapvpwrvgnd_1
XTAP_TAPCELL_ROW_18_47 VSS VDD sky130_fd_sc_hd__tapvpwrvgnd_1
XTAP_TAPCELL_ROW_18_48 VSS VDD sky130_fd_sc_hd__tapvpwrvgnd_1
XTAP_TAPCELL_ROW_18_49 VSS VDD sky130_fd_sc_hd__tapvpwrvgnd_1
XTAP_TAPCELL_ROW_19_50 VSS VDD sky130_fd_sc_hd__tapvpwrvgnd_1
XTAP_TAPCELL_ROW_19_51 VSS VDD sky130_fd_sc_hd__tapvpwrvgnd_1
XTAP_TAPCELL_ROW_20_52 VSS VDD sky130_fd_sc_hd__tapvpwrvgnd_1
XTAP_TAPCELL_ROW_20_53 VSS VDD sky130_fd_sc_hd__tapvpwrvgnd_1
XTAP_TAPCELL_ROW_20_54 VSS VDD sky130_fd_sc_hd__tapvpwrvgnd_1
XTAP_TAPCELL_ROW_21_55 VSS VDD sky130_fd_sc_hd__tapvpwrvgnd_1
XTAP_TAPCELL_ROW_21_56 VSS VDD sky130_fd_sc_hd__tapvpwrvgnd_1
XTAP_TAPCELL_ROW_22_57 VSS VDD sky130_fd_sc_hd__tapvpwrvgnd_1
XTAP_TAPCELL_ROW_22_58 VSS VDD sky130_fd_sc_hd__tapvpwrvgnd_1
XTAP_TAPCELL_ROW_22_59 VSS VDD sky130_fd_sc_hd__tapvpwrvgnd_1
XTAP_TAPCELL_ROW_23_60 VSS VDD sky130_fd_sc_hd__tapvpwrvgnd_1
XTAP_TAPCELL_ROW_23_61 VSS VDD sky130_fd_sc_hd__tapvpwrvgnd_1
XTAP_TAPCELL_ROW_24_62 VSS VDD sky130_fd_sc_hd__tapvpwrvgnd_1
XTAP_TAPCELL_ROW_24_63 VSS VDD sky130_fd_sc_hd__tapvpwrvgnd_1
XTAP_TAPCELL_ROW_24_64 VSS VDD sky130_fd_sc_hd__tapvpwrvgnd_1
XTAP_TAPCELL_ROW_24_65 VSS VDD sky130_fd_sc_hd__tapvpwrvgnd_1
XTAP_TAPCELL_ROW_24_66 VSS VDD sky130_fd_sc_hd__tapvpwrvgnd_1
Xclkbuf_0_clk clk VSS VSS VDD VDD clknet_0_clk sky130_fd_sc_hd__clkbuf_8
Xclkbuf_2_0__f_clk clknet_0_clk VSS VSS VDD VDD clknet_2_0__leaf_clk
+ sky130_fd_sc_hd__clkbuf_8
Xclkbuf_2_1__f_clk clknet_0_clk VSS VSS VDD VDD clknet_2_1__leaf_clk
+ sky130_fd_sc_hd__clkbuf_8
Xclkbuf_2_2__f_clk clknet_0_clk VSS VSS VDD VDD clknet_2_2__leaf_clk
+ sky130_fd_sc_hd__clkbuf_8
Xclkbuf_2_3__f_clk clknet_0_clk VSS VSS VDD VDD clknet_2_3__leaf_clk
+ sky130_fd_sc_hd__clkbuf_8
Xclkload0 clknet_2_0__leaf_clk VSS VSS VDD VDD _unconnected_0
+ sky130_fd_sc_hd__clkbuf_8
Xclkload1 clknet_2_1__leaf_clk VSS VSS VDD VDD _unconnected_1
+ sky130_fd_sc_hd__clkinvlp_4
Xclkload2 clknet_2_3__leaf_clk VSS VSS VDD VDD _unconnected_2
+ sky130_fd_sc_hd__clkinvlp_4
Xload_slew1 _084_ VSS VSS VDD VDD net1 sky130_fd_sc_hd__buf_4
.ENDS UART_8N1_RX
